* NAVCORE-SoOP: VBAT inrush when the battery is plugged in.
* Real values: C17 10u + C18 10u + C19 100n, MLCC ESR ~5 mOhm each.
* Lead = XT60 pigtail + ESC cable, modelled at 300 nH / 20 mOhm.
.title VBAT inrush
Vbat  src 0 PWL(0 0 1u 0 1.05u 16.8)
Lw    src  a   300n
Rw    a    vin 0.020
C17   vin  n17 10u
R17   n17  0   0.005
C18   vin  n18 10u
R18   n18  0   0.005
C19   vin  0   100n
Rload vin  0   1e6
.control
set noaskquit
tran 10n 400u uic
meas tran ipk MAX i(Vbat)
meas tran vfin FIND v(vin) AT=350u
print ipk vfin
.endc
.end
